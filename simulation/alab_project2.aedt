# Ansys Electronics Desktop project, version 2022.2
materials:
  vacuum: permittivity=1

design HFSSDesign1 (HFSS, DrivenModal, model units mm)
variables:
  a_wg = 34.85mm
  b_wg = 15.8mm
  f0 = 7GHz
  la_0 = c0/f0
  n_dielectric = 1
  la_g = la_0/n_dielectric
  l_wg = la_g
  a_h = 50mm
  b_h = 31mm
  l_h = 30mm
geometry:
  wg [vacuum] = box(corner=(-a_wg/2, -b_wg/2, 0mm), size=(a_wg, b_wg, l_wg))
  Rectangle1 = rectangle(corner=(-a_h/2, -b_h/2, l_wg+l_h), x_size=a_h, y_size=b_h)
  horn = object_from(wg.face(+z))
  Rectangle1_ObjectFromFace1 = object_from(Rectangle1.face(#72))
  Rectangle1.delete()
  horn.connect(Rectangle1_ObjectFromFace1)
  Region [vacuum] = region(percentage_offset: +X=50, -X=50, +Y=50, -Y=50, +Z=50, -Z=0)
  wg.unite(horn)
boundaries and excitations:
  FiniteCond1: Finite Conductivity Faces=wg.face(+y, #99, -x, #100, -y, #101, +x, #98) Conductivity=58000000 Permeability=1 IsInternal
  Rad1: Radiation Objects=Region
  1: Wave Port Faces=wg.face(-z) NumModes=1 Modes{Mode1{IntLine{(0, -7.9, 0) -> (0, 7.9, 0)} CharImp=Zpi}}
setups:
  Setup1: HfssDriven Frequency=9GHz MaxDeltaS=0.02 MaximumPasses=6 MinimumPasses=1 MinimumConvergedPasses=1 PercentRefinement=30 BasisOrder=1 PortAccuracy=2 DrivenSolverType="Direct Solver"
    sweep Sweep: 6GHz to 9GHz, 401 points; Type=Fast SaveFields
source amplitudes:
  1:1: 1W 0deg
radiation setups:
  Infinite Sphere1: Infinite Sphere Theta=-180deg..180deg step 2deg Phi=-180deg..180deg step 2deg
reports:
  S Parameter Plot 1: dB(S(1,1)) vs Freq on Setup1 : Sweep; markers m1 at 7GHz
  Realized Gain Plot 1: dB(RealizedGainTotal) vs Phi, Theta on Setup1 : Sweep, Infinite Sphere1 [Freq=7.005GHz]

design HFSSDesign2 (HFSS, DrivenModal, model units mm)
variables:
  a_wg = 34.85mm
  b_wg = 15.8mm
  f0 = 7GHz
  la_0 = c0/f0
  n_dielectric = 1
  la_g = la_0/n_dielectric
  l_wg = la_g
  a_h = 100mm
  b_h = 50mm
  l_h = 130mm
geometry:
  wg [vacuum] = box(corner=(-a_wg/2, -b_wg/2, 0mm), size=(a_wg, b_wg, l_wg))
  Rectangle1 = rectangle(corner=(-a_h/2, -b_h/2, l_wg+l_h), x_size=a_h, y_size=b_h)
  horn = object_from(wg.face(+z))
  Rectangle1_ObjectFromFace1 = object_from(Rectangle1.face(#72))
  Rectangle1.delete()
  horn.connect(Rectangle1_ObjectFromFace1)
  Region [vacuum] = region(percentage_offset: +X=50, -X=50, +Y=50, -Y=50, +Z=50, -Z=0)
  wg.unite(horn)
boundaries and excitations:
  FiniteCond1: Finite Conductivity Faces=wg.face(+y, #99, -x, #100, -y, #101, +x, #98) Conductivity=58000000 Permeability=1 IsInternal
  Rad1: Radiation Objects=Region
  1: Wave Port Faces=wg.face(-z) NumModes=1 Modes{Mode1{IntLine{(0, -7.9, 0) -> (0, 7.9, 0)} CharImp=Zpi}}
setups:
  Setup1: HfssDriven Frequency=9GHz MaxDeltaS=0.02 MaximumPasses=6 MinimumPasses=1 MinimumConvergedPasses=1 PercentRefinement=30 BasisOrder=1 PortAccuracy=2 DrivenSolverType="Direct Solver"
    sweep Sweep: 6GHz to 9GHz, 401 points; Type=Fast SaveFields
source amplitudes:
  1:1: 1W 0deg
radiation setups:
  Infinite Sphere1: Infinite Sphere Theta=-180deg..180deg step 2deg Phi=-180deg..180deg step 2deg
reports:
  S Parameter Plot 1: dB(S(1,1)) vs Freq on Setup1 : Sweep; markers m1 at 7GHz
  Realized Gain Plot 1: dB(RealizedGainTotal) vs Phi, Theta on Setup1 : Sweep, Infinite Sphere1 [Freq=7.005GHz]

design HFSSDesign3 (HFSS, DrivenModal, model units mm)
variables:
  a_wg = 34.85mm
  b_wg = 15.8mm
  f0 = 7GHz
  la_0 = c0/f0
  n_dielectric = 1
  la_g = la_0/n_dielectric
  l_wg = la_g
  a_h = 187.1mm
  b_h = 152.7mm
  l_h = 200mm
geometry:
  wg [vacuum] = box(corner=(-a_wg/2, -b_wg/2, 0mm), size=(a_wg, b_wg, l_wg))
  Rectangle1 = rectangle(corner=(-a_h/2, -b_h/2, l_wg+l_h), x_size=a_h, y_size=b_h)
  horn = object_from(wg.face(+z))
  Rectangle1_ObjectFromFace1 = object_from(Rectangle1.face(#72))
  Rectangle1.delete()
  horn.connect(Rectangle1_ObjectFromFace1)
  Region [vacuum] = region(percentage_offset: +X=50, -X=50, +Y=50, -Y=50, +Z=50, -Z=0)
  wg.unite(horn)
boundaries and excitations:
  FiniteCond1: Finite Conductivity Faces=wg.face(+y, #99, -x, #100, -y, #101, +x, #98) Conductivity=58000000 Permeability=1 IsInternal
  Rad1: Radiation Objects=Region
  1: Wave Port Faces=wg.face(-z) NumModes=1 Modes{Mode1{IntLine{(0, -7.9, 0) -> (0, 7.9, 0)} CharImp=Zpi}}
setups:
  Setup1: HfssDriven Frequency=9GHz MaxDeltaS=0.02 MaximumPasses=6 MinimumPasses=2 MinimumConvergedPasses=1 PercentRefinement=20 BasisOrder=1 PortAccuracy=2 DrivenSolverType="Direct Solver"
    sweep Sweep: 6GHz to 9GHz, 401 points; Type=Fast SaveFields
source amplitudes:
  1:1: 1W 0deg
radiation setups:
  Infinite Sphere1: Infinite Sphere Theta=-180deg..180deg step 2deg Phi=-180deg..180deg step 2deg
reports:
  S Parameter Plot 1: dB(S(1,1)) vs Freq on Setup1 : Sweep; markers m1 at 7GHz
  Realized Gain Plot 1: dB(RealizedGainTotal) vs Phi, Theta on Setup1 : Sweep, Infinite Sphere1 [Freq=7.005GHz]
